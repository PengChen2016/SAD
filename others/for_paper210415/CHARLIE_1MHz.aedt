# Ansys Electronics Desktop project, version 2015.1
project variables:
  $eps_r = -435770
  $sigma = 96.3898
materials:
  vacuum: permittivity=1
  copper: permeability=0.999991 conductivity=58000000
  plasma: permittivity=$eps_r conductivity=$sigma
  steel_stainless: conductivity=1100000

design 1MHz (HFSS, DrivenModal, model units mm)
variables:
  region_r = 250mm
  wire_len = 150m
geometry:
  plate_1 [steel_stainless] = cylinder(axis=Z, base_centre=(0mm, 0mm, -200mm), radius=80mm, height=-5mm)
  Cylinder3 = cylinder(axis=Z, base_centre=(0mm, 0mm, -205mm), radius=30mm, height=-15mm)
  Cylinder4 = cylinder(axis=Z, base_centre=(0mm, 0mm, -200mm), radius=25mm, height=-20mm)
  plate_1.unite(Cylinder3)
  plate_1.subtract(Cylinder4)
  plate_2 [steel_stainless] = plate_1.duplicate_mirror(point=(0mm, 0mm, 0mm), normal=(0mm, 0mm, 1mm))
  coil [copper] = user_primitive(SegmentedHelix/PolygonHelix.dll, PolygonSegments=0, PolygonRadius=3mm, StartHelixRadius=55mm, RadiusChange=0mm, Pitch=20mm, Turns=5, SegmentsPerTurn=0, RightHanded=1)
  coil.move(0mm, 0mm, -50mm)
  Sphere1 = sphere(centre=(55mm, 0mm, -50mm), radius=3.0054057mm)
  Cylinder1 = cylinder(axis=X, base_centre=(55mm, 0mm, -50mm), radius=3mm, height=wire_len)
  Sphere1_1 = Sphere1.duplicate_along_line(step=(0mm, 0mm, 100mm), total=2)
  Cylinder1_1 = Cylinder1.duplicate_along_line(step=(0mm, 0mm, 100mm), total=2)
  Sphere2 = sphere(centre=(55e-3+wire_len, 0mm, -50mm), radius=3mm)
  Cylinder2 = cylinder(axis=Z, base_centre=(55e-3+wire_len, 0mm, -50mm), radius=3mm, height=49.5mm)
  Cylinder2_1 = Cylinder2.duplicate_mirror(point=(0mm, 0mm, 0mm), normal=(0mm, 0mm, 1mm))
  Sphere2_1 = Sphere2.duplicate_mirror(point=(0mm, 0mm, 0mm), normal=(0mm, 0mm, 1mm))
  source [vacuum] = cylinder(axis=Z, base_centre=(55e-3+wire_len, 0mm, -0.5mm), radius=3mm, height=1mm)
  region [vacuum] = cylinder(axis=Z, base_centre=(0mm, 0mm, -240mm), radius=region_r, height=480mm)
  Axi [non-model] = polyline((0mm, 0mm, -200mm) (0mm, 0mm, 200mm))
  diameter_x [non-model] = polyline((-45mm, 0mm, 0mm) (45mm, 0mm, 0mm))
  diameter_y [non-model] = polyline((0mm, -45mm, 0mm) (0mm, 45mm, 0mm))
  xy [non-model] = circle(normal=Z, centre=(0mm, 0mm, 0mm), radius=60mm)
  xz [non-model] = rectangle(corner=(-60mm, 0mm, -200mm), z_size=400mm, x_size=120mm)
  axi_x0y44 [non-model] = polyline((0mm, 44mm, -200mm) (0mm, 44mm, 200mm))
  plasma [vacuum, non-model] = cylinder(axis=Z, base_centre=(0mm, 0mm, -200mm), radius=45mm, height=400mm)
  coil.unite(Cylinder1, Cylinder1_1, Cylinder2, Cylinder2_1, Sphere1, Sphere1_1, Sphere2, Sphere2_1)
  Is_r3dz0 [non-model] = circle(normal=Z, centre=(205mm, 0mm, 0mm), radius=3mm, uncovered)
  Is_r3dz1 [non-model] = circle(normal=Z, centre=(205mm, 0mm, 1mm), radius=3mm, uncovered)
  Is_r3_2dz0 [non-model] = circle(normal=Z, centre=(205mm, 0mm, 0mm), radius=3.2mm, uncovered)
  Is_r3_2dz1 [non-model] = circle(normal=Z, centre=(205mm, 0mm, 1mm), radius=3.2mm, uncovered)
  Us_x0y0h1_0 [non-model] = polyline((205mm, 0mm, -0.5mm) (205mm, 0mm, 0.5mm))
  Us_x2y0h1_0 [non-model] = polyline((207mm, 0mm, -0.5mm) (207mm, 0mm, 0.5mm))
  axi_x0yn44 [non-model] = polyline((0mm, -44mm, -200mm) (0mm, -44mm, 200mm))
  plasma_yz [non-model] = rectangle(corner=(0mm, -43mm, -200mm), y_size=86mm, z_size=400mm)
  plasma1 [plasma] = cylinder(axis=Z, base_centre=(0mm, 0mm, -200mm), radius=45mm, height=400mm)
  radial_y [non-model] = polyline((0mm, 0mm, 0mm) (0mm, 55mm, 0mm))
boundaries and excitations:
  Rad1: Radiation Faces=region.face(all 3)
  Voltage1: Voltage Faces=source.face(1 of 3) Direction{middle of source.edge(2 of 2) -> middle of source.edge(1 of 2)}
mesh:
  in4: LengthBased Objects=plasma1 MaxLength=4mm
  SurfApprox10: SurfApproxBased Objects=plasma1 SurfDevChoice=0 NormalDevChoice=2 NormalDev=10deg AspectRatioChoice=1 SetFacePreservationLevel=0
  initial mesh: GlobalSurfApproximation{SurfDevChoice=0 NormalDevChoice=1 AspectRatioChoice=1 SetFacePreservationLevel=0}
setups:
  1MHz: HfssDriven Frequency=1MHz MaxDeltaE=1 MaximumPasses=10 MinimumPasses=1 MinimumConvergedPasses=1 PercentRefinement=30 BasisOrder=1 IterativeResidual=1e-006 DDMSolverResidual=0.0001
source amplitudes:
  Voltage1:1: 100V 0deg
optimetrics:
  not_magnetized: Parametric ProdOptiSetupData{SaveFields} Sim._Setups=[1MHz]
    sweep $eps_r: 1
    sweep $sigma: 1
    table edits: edit(1, 1, -29620, 1) edit(-29620, 1, -29620, 37.6596) add(-29620, 37.6596) edit(-29620, 37.6596, 1, 37.6596) edit(1, 37.6596, 1, 38.8137) add(-29620, 37.6596) edit(-29620, 37.6596, 1, 37.6596) edit(1, 37.6596, 1, 0) add(-29620, 37.6596) add(-29620, 37.6596) add(-29620, 37.6596) add(-29620, 37.6596) add(-29620, 37.6596) add(-29620, 37.6596) add(-29620, 37.6596) edit(1, 38.8137, -205340, 38.8137) edit(1, 0, -240980, 0) edit(-29620, 37.6596, -238260, 37.6596) edit(-29620, 37.6596, -115250, 37.6596) edit(-29620, 37.6596, -72300, 37.6596) edit(-29620, 37.6596, 1, 37.6596) edit(-29620, 37.6596, 1, 37.6596) edit(-29620, 37.6596, 1, 37.6596) edit(-29620, 37.6596, 1, 37.6596) edit(-205340, 38.8137, -205340, 34.2124) edit(-240980, 0, -240980, 48.9329) edit(-238260, 37.6596, -238260, 66.5802) edit(-115250, 37.6596, -115250, 59.3504) edit(-72300, 37.6596, -72300, 53.7952) edit(1, 37.6596, 1, 95.2438) edit(1, 37.6596, 1, 107.7007) edit(1, 37.6596, 1, 108.803) edit(1, 37.6596, 1, 70.4325) add(1, 70.4325) add(1, 70.4325) add(1, 70.4325) edit(1, 70.4325, 1, 58.6074) edit(1, 70.4325, 1, 38.8137) edit(1, 70.4325, 1, 0) edit(-205340, 34.2124, -570710, 34.2124) edit(-240980, 48.9329, -634410, 48.9329) edit(-238260, 66.5802, -435770, 66.5802) edit(-115250, 59.3504, -144690, 59.3504) edit(-72300, 53.7952, -67130, 53.7952) edit(1, 95.2438, -20250, 95.2438) edit(-29620, 37.6596, 1, 37.6596) edit(-570710, 34.2124, -570710, 65.7212) edit(-634410, 48.9329, -634410, 97.4595) edit(-435770, 66.5802, -435770, 96.3898) edit(-144690, 59.3504, -144690, 67.1411) edit(-67130, 53.7952, -67130, 46.0053) edit(-20250, 95.2438, -20250, 24.2948) edit(1, 107.7007, 1, 81.06) edit(1, 108.803, 1, 110.2406) edit(1, 58.6074, 1, 102.4871) edit(1, 37.6596, 1, 68.1062) edit(1, 38.8137, 1, 46.3084) edit(1, 0, 1, 24.3471) edit(1, 70.4325, 1, 0)
  magnetized: Parametric ProdOptiSetupData{SaveFields} Sim._Setups=[1MHz]
    sweep $eps_r: 1
    sweep $sigma: 1
    table edits: add(1, 1) add(1, 1) add(1, 1) add(1, 1) add(1, 1) edit(1, 1, -8, 1) edit(-8, 1, -8, 1.84) edit(1, 1, -62, 1) edit(-62, 1, -62, 4.88) edit(1, 1, 1, 8.19) edit(1, 8.19, -237, 8.19) edit(1, 1, -660, 1) edit(-660, 1, -660, 11.24) edit(1, 1, 1, 9.70) edit(1, 9.70, -622, 9.70) edit(1, 1, -387, 1) edit(-387, 1, -387, 6.50)
field calculator expressions:
  Mag_Ephi = Vector_E | ScalarY | Scalar_Function(FuncValue='PHI') | UMathFunc | * | Vector_E | ScalarX | Scalar_Function(FuncValue='PHI') | UMathFunc | * | -
  Mag_Erho = Vector_E | ScalarX | Scalar_Function(FuncValue='PHI') | UMathFunc | * | Vector_E | ScalarY | Scalar_Function(FuncValue='PHI') | UMathFunc | * | +
  Mag_Ez = Vector_E | ScalarZ
  Mag_Hphi = Vector_H | ScalarY | Scalar_Function(FuncValue='PHI') | UMathFunc | * | Vector_H | ScalarX | Scalar_Function(FuncValue='PHI') | UMathFunc | * | -
  Mag_Hrho = Vector_H | ScalarX | Scalar_Function(FuncValue='PHI') | UMathFunc | * | Vector_H | ScalarY | Scalar_Function(FuncValue='PHI') | UMathFunc | * | +
  Mag_Hz = Vector_H | ScalarZ
  Vec_Ephi = Vector_Constant(0, 1, 0) | Mag_Ephi | Scalar_Function(FuncValue='PHI') | UMathFunc | * | * | Vector_Constant(1, 0, 0) | Mag_Ephi | Scalar_Function(FuncValue='PHI') | UMathFunc | * | * | -
  Vec_Erho = Vector_Constant(1, 0, 0) | Mag_Erho | Scalar_Function(FuncValue='PHI') | UMathFunc | * | * | Vector_Constant(0, 1, 0) | Mag_Erho | Scalar_Function(FuncValue='PHI') | UMathFunc | * | * | +
  Vec_Ez = Mag_Ez | VecZ
  Vec_Hphi = Scalar_Function(FuncValue='PHI') | UMathFunc | Mag_Hphi | * | VecY | Scalar_Function(FuncValue='PHI') | UMathFunc | Mag_Hphi | * | VecX | -
  Vec_Hrho = Scalar_Function(FuncValue='PHI') | UMathFunc | Mag_Hrho | * | VecY | Scalar_Function(FuncValue='PHI') | UMathFunc | Mag_Hrho | * | VecX | +
  Vec_Hz = Mag_Hz | VecZ
  cpx_Is_r3dz0 = <Hx,Hy,Hz> | Real | Tangent | Dot | EnterLine(Is_r3dz0) | LineValue | Integrate | CmplxR | <Hx,Hy,Hz> | Imag | Tangent | Dot | EnterLine(Is_r3dz0) | LineValue | Integrate | CmplxI | +
  cMag_Is_r3dz0 = cpx_Is_r3dz0 | CmplxMag
  cPhase_Is_r3dz0 = cpx_Is_r3dz0 | Phase | 180 | * | 3.14159265358979 | /
  cpx_Is_r3dz1 = <Hx,Hy,Hz> | Real | Tangent | Dot | EnterLine(Is_r3dz1) | LineValue | Integrate | CmplxR | <Hx,Hy,Hz> | Imag | Tangent | Dot | EnterLine(Is_r3dz1) | LineValue | Integrate | CmplxI | +
  cMag_Is_r3dz1 = cpx_Is_r3dz1 | CmplxMag
  cPhase_Is_r3dz1 = cpx_Is_r3dz1 | Phase | 180 | * | 3.14159265358979 | /
  cpx_Is_r3_2dz0 = <Hx,Hy,Hz> | Real | Tangent | Dot | EnterLine(Is_r3_2dz0) | LineValue | Integrate | CmplxR | <Hx,Hy,Hz> | Imag | Tangent | Dot | EnterLine(Is_r3_2dz0) | LineValue | Integrate | CmplxI | +
  cMag_Is_r3_2dz0 = cpx_Is_r3_2dz0 | CmplxMag
  cPhase_Is_r3_2dz0 = cpx_Is_r3_2dz0 | Phase | 180 | * | 3.14159265358979 | /
  cpx_Is_r3_2dz1 = <Hx,Hy,Hz> | Real | Tangent | Dot | EnterLine(Is_r3_2dz1) | LineValue | Integrate | CmplxR | <Hx,Hy,Hz> | Imag | Tangent | Dot | EnterLine(Is_r3_2dz1) | LineValue | Integrate | CmplxI | +
  cMag_Is_r3_2dz1 = cpx_Is_r3_2dz1 | CmplxMag
  cPhase_Is_r3_2dz1 = cpx_Is_r3_2dz1 | Phase | 180 | * | 3.14159265358979 | /
  cpx_Us_x0y0h1_0 = Fundamental_Quantity(0) | Real | Tangent | Dot | EnterLine(Us_x0y0h1_0) | LineValue | Integrate | CmplxR | Fundamental_Quantity(0) | Imag | Tangent | Dot | EnterLine(Us_x0y0h1_0) | LineValue | Integrate | CmplxI | +
  cMag_Us_x0y0h1_0 = cpx_Us_x0y0h1_0 | CmplxMag
  cPhase_Us_x0y0h1_0 = cpx_Us_x0y0h1_0 | Phase | 180 | * | 3.14159265358979 | /
  cpx_Us_x2y0h1_0 = Fundamental_Quantity(0) | Real | Tangent | Dot | EnterLine(Us_x2y0h1_0) | LineValue | Integrate | CmplxR | Fundamental_Quantity(0) | Imag | Tangent | Dot | EnterLine(Us_x2y0h1_0) | LineValue | Integrate | CmplxI | +
  cMag_Us_x2y0h1_0 = cpx_Us_x2y0h1_0 | CmplxMag
  cPhase_Us_x2y0h1_0 = cpx_Us_x2y0h1_0 | Phase | 180 | * | 3.14159265358979 | /
  plasma_Ss = Poynting | Real | Normal | Dot | EnterSurface(plasma) | SurfaceValue | Integrate | Neg | CmplxR | Poynting | Imag | Normal | Dot | EnterSurface(plasma) | SurfaceValue | Integrate | Neg | CmplxI | +
  plasma_Lossv = VolumeLossDensity | EnterVolume(plasma) | VolumeValue | Integrate
  coil_Ss = Poynting | Real | Normal | Dot | EnterSurface(coil) | SurfaceValue | Integrate | Neg | CmplxR | Poynting | Imag | Normal | Dot | EnterSurface(coil) | SurfaceValue | Integrate | Neg | CmplxI | +
  coil_Losss = Fundamental_Quantity(4) | EnterSurface(coil) | SurfaceValue | Integrate
  coil_surfZs = Fundamental_Quantity(1) | CmplxMag | Fundamental_Quantity(1) | CmplxMag | Dot | EnterSurface(coil) | SurfaceValue | Integrate | 0.000260895069422349 | * | 2 | /
  plate_1_Ss = Poynting | Real | Normal | Dot | EnterSurface(plate_1) | SurfaceValue | Integrate | Neg | CmplxR | Poynting | Imag | Normal | Dot | EnterSurface(plate_1) | SurfaceValue | Integrate | Neg | CmplxI | +
  plate_1_Losss = Fundamental_Quantity(4) | EnterSurface(plate_1) | SurfaceValue | Integrate
  plate_1_surfZs = Fundamental_Quantity(1) | CmplxMag | Fundamental_Quantity(1) | CmplxMag | Dot | EnterSurface(plate_1) | SurfaceValue | Integrate | 0.00189445165019897 | * | 2 | /
  plate_2_Ss = Poynting | Real | Normal | Dot | EnterSurface(plate_2) | SurfaceValue | Integrate | Neg | CmplxR | Poynting | Imag | Normal | Dot | EnterSurface(plate_2) | SurfaceValue | Integrate | Neg | CmplxI | +
  plate_2_Losss = Fundamental_Quantity(4) | EnterSurface(plate_2) | SurfaceValue | Integrate
  plate_2_surfZs = Fundamental_Quantity(1) | CmplxMag | Fundamental_Quantity(1) | CmplxMag | Dot | EnterSurface(plate_2) | SurfaceValue | Integrate | 0.00189445165019897 | * | 2 | /
  PER = plasma_Lossv | 2 | * | cMag_Is_r3dz0 | cMag_Is_r3dz0 | * | /
  Rmetal = 2 | coil_Losss | plate_1_Losss | plate_2_Losss | + | + | * | cMag_Is_r3dz0 | cMag_Is_r3dz0 | * | /
  Ls = 1000000 | cMag_Us_x0y0h1_0 | cMag_Is_r3dz0 | / | cMag_Us_x0y0h1_0 | cMag_Is_r3dz0 | / | * | PER | Rmetal | + | PER | Rmetal | + | * | - | Sqrt | 6.28318530717958 | Scalar_Function(FuncValue='Freq') | * | / | *
  cHz = <Hx,Hy,Hz> | ScalarZ | CmplxMag
field plots:
  Vector_E1: E_xz over xz.face on 1MHz : LastAdaptive at Freq=0.004GHz Phase=0deg
  Vector_E2: E_xy over xy.face on 1MHz : LastAdaptive at Freq=0.004GHz Phase=0deg
  Vector_H1: H_xy over xy.face on 1MHz : LastAdaptive at Freq=0.004GHz Phase=0deg
  Vector_H2: H_xz over xy.face on 1MHz : LastAdaptive at Freq=0.004GHz Phase=0deg
  ComplexMag_E1: E Field over xz.face on 1MHz : LastAdaptive at Freq=0.004GHz Phase=0deg
  ComplexMag_H1: H Field over xz.face on 1MHz : LastAdaptive at Freq=0.004GHz Phase=0deg
  Volume_Loss_Density1: Volume Loss Density over a plane on 1MHz : LastAdaptive at Freq=0.004GHz Phase=0deg
reports:
  Axi: ComplexMag_E, ComplexMag_H, Mag_E, Mag_H vs Distance-200 on 1MHz : LastAdaptive [Freq=all Phase=0deg region_r=all wire_len=all]
  diameter_x: ComplexMag_E, ComplexMag_H, Mag_E, Mag_H vs Distance-200 on 1MHz : LastAdaptive [Freq=all Phase=0deg region_r=all wire_len=all]
  diameter_y: ComplexMag_E, ComplexMag_H, Mag_E vs Distance-200 on 1MHz : LastAdaptive [Freq=all Phase=0deg region_r=all wire_len=all]; Mag_H vs Distance on 1MHz : LastAdaptive [Freq=all Phase=0deg,90deg region_r=all wire_len=all $eps_r=all $sigma=24.2948]
  diameter_y_Jvol: ComplexMag_Jvol vs Distance on 1MHz : LastAdaptive [Freq=all Phase=0deg region_r=all wire_len=all]
  Is: cpx_Is_r3dz0, cPhase_Is_r3dz0, cpx_Is_r3dz1, cMag_Is_r3dz1, cPhase_Is_r3dz1, cpx_Is_r3_2dz0, cMag_Is_r3_2dz0, cPhase_Is_r3_2dz0, cpx_Is_r3_2dz1, cMag_Is_r3_2dz1, cPhase_Is_r3_2dz1 vs Freq on 1MHz : LastAdaptive [Phase=0deg]; cMag_Is_r3dz0 vs Freq on 1MHz : LastAdaptive [Phase=0deg $eps_r=all $sigma=65.7212]
  Us_y0h2: cpx_Us_x0y0h1_0, cMag_Us_x0y0h1_0, cPhase_Us_x0y0h1_0, cpx_Us_x2y0h1_0, cMag_Us_x2y0h1_0, cPhase_Us_x2y0h1_0 vs Freq on 1MHz : LastAdaptive [Phase=0deg]
  plasma_power: plasma_Ss vs Freq on 1MHz : LastAdaptive [Phase=0deg $eps_r=all $sigma=all]; plasma_Lossv vs Freq on 1MHz : LastAdaptive [Phase=0deg]
  conductor_power: coil_Ss, coil_Losss, coil_surfZs, plate_1_Ss, plate_1_Losss, plate_1_surfZs, plate_2_Ss, plate_2_Losss, plate_2_surfZs vs Freq on 1MHz : LastAdaptive [Phase=0deg]
  axi_x0yn44: ComplexMag_E, ComplexMag_H, Mag_E, Mag_H vs Distance-200 on 1MHz : LastAdaptive [Freq=all Phase=0deg]
  diameter_y_phases: Mag_E vs Distance-45e-3 on 1MHz : LastAdaptive [Freq=all Phase=0deg,15deg,30deg,45deg,60deg,75deg,90deg,105deg,120deg,135deg,150deg,165deg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 region_r=all wire_len=all]
  Data Table 1: PER, Rmetal, Ls vs $sigma on 1MHz : LastAdaptive [Phase=0deg Freq=all $eps_r=all]
  Data Table 2: PER, Rmetal, Ls vs $sigma on 1MHz : LastAdaptive [Phase=0deg Freq=all $eps_r=-660,-622,-387,-237,-62,-8]
  XY Plot 1: Volume_Loss_Density vs Distance on 1MHz : LastAdaptive [Freq=all Phase=0deg $eps_r=all $sigma=24.2948]
  XY Plot 2: Mag_Ephi, Mag_Erho, Mag_Ez vs Distance on 1MHz : LastAdaptive [Freq=all Phase=0deg $eps_r=all $sigma=24.2948]
  XY Plot 3: Mag_Hphi, Mag_Hrho, Mag_Hz, cHz vs Distance on 1MHz : LastAdaptive [Freq=all Phase=90deg region_r=all wire_len=all $eps_r=all $sigma=65.7212]
